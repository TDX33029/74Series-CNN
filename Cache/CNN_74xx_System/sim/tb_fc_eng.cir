* FC1+FC2 full address/MAC sequence (behavioral counter)
Bstep step 0 V = floor(time/100n)
Bsel sel 0 V = (V(step) < 12800) ? 0 : 1
Bs1 s1 0 V = V(step)
Bs2 s2 0 V = V(step)-12800
Bn1 n1 0 V = floor(V(s1)/400)
Bi1 i1 0 V = V(s1)-400*V(n1)
Bn2 n2 0 V = floor(V(s2)/32)
Bi2 i2 0 V = V(s2)-32*V(n2)
Bn n 0 V = (V(sel) < 0.5) ? V(n1) : V(n2)
Bi idx 0 V = (V(sel) < 0.5) ? V(i1) : V(i2)
Bina ina 0 V = V(idx)
Bwa wa 0 V = (V(sel) < 0.5) ? V(n)*400+V(idx) : V(n)*32+V(idx)
Boa oa 0 V = (V(sel) < 0.5) ? V(n) : V(n)*4
.tran 100n 1.312000m
.meas tran in_max max V(ina)
.meas tran in_min min V(ina)
.meas tran w_max max V(wa)
.meas tran w_min min V(wa)
.meas tran out_max max V(oa)
.meas tran out_min min V(oa)
.meas tran step_max max V(step)
.end
