* 8x8 LUT multiplier representative-pair test
Va a 0 PWL(0.0n 0 1.0n 0 200.0n 0 200.0n 1 201.0n 1 400.0n 1 400.0n 255 401.0n 255 600.0n 255 600.0n 123 601.0n 123 800.0n 123 800.0n 0 801.0n 0 1000.0n 0 1000.0n 255 1001.0n 255 1200.0n 255 1200.0n 128 1201.0n 128 1400.0n 128 1400.0n 200 1401.0n 200 1600.0n 200)
Vb b 0 PWL(0.0n 0 1.0n 0 200.0n 0 200.0n 1 201.0n 1 400.0n 1 400.0n 255 401.0n 255 600.0n 255 600.0n 45 601.0n 45 800.0n 45 800.0n 255 801.0n 255 1000.0n 255 1000.0n 0 1001.0n 0 1200.0n 0 1200.0n 127 1201.0n 127 1400.0n 127 1400.0n 100 1401.0n 100 1600.0n 100)
Bp prod 0 V = V(a)*V(b)
Blo lo 0 V = V(a)*V(b)-256*floor(V(a)*V(b)/256)
Bhi hi 0 V = floor(V(a)*V(b)/256)
.tran 1n 1610.0n
.end
