* CONV2 full address/MAC sequence (behavioral counter)
Bstep step 0 V = floor(time/100n)
Bpt pt 0 V = floor(V(step)/72)
Bm m 0 V = V(step)-72*V(pt)
Bic ic 0 V = floor(V(m)/9)
Bmm mm 0 V = V(m)-9*V(ic)
Bky ky 0 V = floor(V(mm)/3)
Bkx kx 0 V = V(mm)-3*V(ky)
Boc oc 0 V = floor(V(pt)/100)
Brem rem 0 V = V(pt)-100*V(oc)
Boy oy 0 V = floor(V(rem)/10)
Box ox 0 V = V(rem)-10*V(oy)
Bina ina 0 V = V(ic)*144+(V(oy)+V(ky))*12+(V(ox)+V(kx))
Bwa wa 0 V = V(oc)*72+V(ic)*9+V(ky)*3+V(kx)
Boa oa 0 V = V(oc)*100+V(oy)*10+V(ox)
.tran 100n 11.520000m
.meas tran in_max max V(ina)
.meas tran in_min min V(ina)
.meas tran w_max max V(wa)
.meas tran w_min min V(wa)
.meas tran out_max max V(oa)
.meas tran out_min min V(oa)
.meas tran step_max max V(step)
.end
