* CONV1 full address/MAC sequence (behavioral counter)
Bstep step 0 V = floor(time/100n)
Bpt pt 0 V = floor(V(step)/25)
Bm m 0 V = V(step)-25*V(pt)
Bky ky 0 V = floor(V(m)/5)
Bkx kx 0 V = V(m)-5*V(ky)
Boc oc 0 V = floor(V(pt)/576)
Brem rem 0 V = V(pt)-576*V(oc)
Boy oy 0 V = floor(V(rem)/24)
Box ox 0 V = V(rem)-24*V(oy)
Bina ina 0 V = (V(oy)+V(ky))*28+(V(ox)+V(kx))
Bwa wa 0 V = V(oc)*25+V(ky)*5+V(kx)
Boa oa 0 V = V(oc)*576+V(oy)*24+V(ox)
Bactive act 0 V = (V(step) < 115200) ? 1 : 0
.tran 100n 11.520000m
.meas tran in_max max V(ina)
.meas tran in_min min V(ina)
.meas tran w_max max V(wa)
.meas tran w_min min V(wa)
.meas tran out_max max V(oa)
.meas tran out_min min V(oa)
.meas tran step_max max V(step)
.end
